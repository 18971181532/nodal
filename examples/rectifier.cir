half-wave rectifier
V1 in 0 SIN(0 5 1k)
D1 in out DIDEAL
R1 out 0 1k
C1 out 0 10u
.model DIDEAL D(IS=1e-14 N=1)
.tran 20u 5m
.end
