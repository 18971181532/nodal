RLC bandpass
V1 in 0 DC 0 AC 1
R1 in mid 10
L1 mid out 1m
C1 out 0 1u
R2 out 0 1k
.ac dec 40 100 1meg
.end
